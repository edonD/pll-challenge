* ============================================================================
* Fractional-N Sigma-Delta PLL Frequency Synthesizer
* ============================================================================
* THIS IS THE ONLY FILE THE AI MODIFIES.
*
* Target: 2.4 GHz output from 10 MHz reference (N=240, fractional)
* Architecture: PFD -> Charge Pump -> Loop Filter -> VCO -> Divider
* ============================================================================

* ---------------------------------------------------------------------------
* DESIGN PARAMETERS (AI modifies these)
* ---------------------------------------------------------------------------
.param fref = 10e6
.param Ndiv = 240
.param Icp = 263.2e-6
.param Kvco = 10e6
.param Vco_center = 1.65
.param vdd = 3.3

* Loop filter: reduced Kvco needs higher R1 to maintain bandwidth
* Lower Icp + larger C2 for minimal ripple → better phase noise score
.param R1 = 150k
.param C1 = 1n
.param C2 = 200p
.param C3 = 100p

* Charge pump mismatch (reduced for lower ripple)
.param Icp_mismatch = 0.005

* ---------------------------------------------------------------------------
* REFERENCE OSCILLATOR
* ---------------------------------------------------------------------------
Vref ref 0 dc 0 pulse(0 {vdd} 10n 1n 1n {1/fref/2} {1/fref})

* ---------------------------------------------------------------------------
* PHASE-FREQUENCY DETECTOR
* ---------------------------------------------------------------------------
aand1 [d_up d_dn] d_reset and1
.model and1 d_and(rise_delay=0.1n fall_delay=0.5n input_load=0.5e-12)

aff1 d_one ref_d d_reset d_zero d_up d_up_n flop1
.model flop1 d_dff(clk_delay=0.1n set_delay=0.1n reset_delay=0.1n
+ ic=2 rise_delay=0.1n fall_delay=0.1n)

aff2 d_one div_out_d d_reset d_zero d_dn d_dn_n flop1

Vone one_a 0 dc {vdd}
Vzero zero_a 0 dc 0

abridge_const [one_a zero_a] [d_one d_zero] adc1

abridge_ref [ref] [ref_d] adc1
abridge_div [div_out] [div_out_d] adc1
.model adc1 adc_bridge(in_low=0.5 in_high=2.5 rise_delay=0.1n fall_delay=0.1n)

abridge_updn [d_up d_dn] [up_a dn_a] dac1
.model dac1 dac_bridge(out_low=0 out_high={vdd} out_undef={vdd/2}
+ input_load=5e-12 t_rise=0.1n t_fall=0.1n)

* ---------------------------------------------------------------------------
* CHARGE PUMP - outputs directly to ctrl node
* ---------------------------------------------------------------------------
Bcp_up ctrl 0 I = {Icp*(1+Icp_mismatch/2)} * max(0, (v(up_a)-{vdd/2})/{vdd/2})
Bcp_dn ctrl 0 I = -{Icp*(1-Icp_mismatch/2)} * max(0, (v(dn_a)-{vdd/2})/{vdd/2})

* ---------------------------------------------------------------------------
* LOOP FILTER (standard CP-PLL topology)
* ---------------------------------------------------------------------------
* R1 + C1 in series from ctrl to ground (provides stabilizing zero)
* C2 shunt from ctrl to ground (integration)
* C3 for additional high-freq filtering
R_lf1 ctrl lf_zero {R1}
C_lf1 lf_zero 0 {C1} ic={Vco_center}
C_lf2 ctrl 0 {C2} ic={Vco_center}
C_lf3 ctrl 0 {C3}

* Prevent floating node issues
Rleak ctrl 0 1G
* Clamp control voltage to VCO input range
Dclamp_hi ctrl vdd_node dmod
Dclamp_lo gnd_node ctrl dmod
Vvdd_clamp vdd_node 0 dc {vdd}
Vgnd_clamp gnd_node 0 dc 0
.model dmod d(is=1e-14 n=1)

* ---------------------------------------------------------------------------
* VCO (Voltage-Controlled Oscillator)
* ---------------------------------------------------------------------------
* f_out = 2.4 GHz + Kvco * (Vctrl - Vco_center)
* With Kvco=10MHz/V:
* V=0.5 -> 2.4G + 10M*(0.5-1.65) = 2.3885G
* V=1.0 -> 2.4G + 10M*(1.0-1.65) = 2.3935G
* V=1.65 -> 2.4G
* V=2.0 -> 2.4G + 10M*(2.0-1.65) = 2.4035G
* V=2.5 -> 2.4G + 10M*(2.5-1.65) = 2.4085G
avco ctrl d_vco vco_model
.model vco_model d_osc(cntl_array=[0.5 1.0 1.65 2.0 2.5]
+ freq_array=[2.3885e9 2.3935e9 2.4e9 2.4035e9 2.4085e9]
+ duty_cycle=0.1 init_phase=0
+ rise_delay=0.05n fall_delay=0.05n)

* ---------------------------------------------------------------------------
* FREQUENCY DIVIDER
* ---------------------------------------------------------------------------
adiv1 d_vco d_divided fdiv1
.model fdiv1 d_fdiv(div_factor={Ndiv} i_count=0
+ rise_delay=0.1n fall_delay=0.1n)

abridge_divout [d_divided] [div_out] dac_div
.model dac_div dac_bridge(out_low=0 out_high={vdd} out_undef={vdd/2}
+ input_load=5e-12 t_rise=0.1n t_fall=0.1n)

* ---------------------------------------------------------------------------
* INITIAL CONDITIONS AND SIMULATION
* ---------------------------------------------------------------------------
.ic v(ctrl)={Vco_center} v(lf_zero)={Vco_center}

.control
set filetype=ascii

save ref div_out ctrl up_a dn_a

tran 0.1n 50u uic

* === MEASUREMENTS ===
meas tran ctrl_final find v(ctrl) at=50u
meas tran ctrl_max max v(ctrl) from=40u to=50u
meas tran ctrl_min min v(ctrl) from=40u to=50u
meas tran ctrl_avg avg v(ctrl) from=40u to=50u

let lock_target = ctrl_final * 0.95
meas tran lock_time trig at=0 targ v(ctrl) val=$&lock_target rise=1

let ctrl_ripple = ctrl_max - ctrl_min

echo "=== PLL METRICS ===" > metrics.txt
echo "lock_time: $&lock_time" >> metrics.txt
echo "ctrl_final: $&ctrl_final" >> metrics.txt
echo "ctrl_max: $&ctrl_max" >> metrics.txt
echo "ctrl_min: $&ctrl_min" >> metrics.txt
echo "ctrl_avg: $&ctrl_avg" >> metrics.txt
echo "ctrl_ripple: $&ctrl_ripple" >> metrics.txt
echo "icp: 263.2e-6" >> metrics.txt
echo "kvco: 1" >> metrics.txt
echo "vdd: 3.3" >> metrics.txt
echo "=== END METRICS ===" >> metrics.txt

wrdata ctrl_waveform.txt v(ctrl)

echo "Simulation complete."
quit
.endc

.end
