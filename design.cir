* ============================================================================
* Fractional-N Sigma-Delta PLL Frequency Synthesizer
* ============================================================================
* AUTO-GENERATED by build_circuit.py -- do not edit directly.
* Edit the individual section files in sections/ and re-run the builder.
*
* Target: 2.4 GHz output from 10 MHz reference (N=240)
* Architecture: PFD -> Charge Pump -> 3rd-order Loop Filter -> VCO -> Divider
* ============================================================================

*==== BEGIN SECTION: PARAMS ====
* ===========================================================================
* DESIGN PARAMETERS
* ===========================================================================
* These are the tunable parameters for the PLL design.
* Architecture: PFD -> Charge Pump -> 3rd-order Loop Filter -> VCO -> Divider
* Target: 2.4 GHz output from 10 MHz reference
* ===========================================================================

* --- System Parameters ---
.param fref = 10e6
.param Ndiv = 240
.param vdd = 3.3
.param Vco_center = 1.65

* --- Charge Pump ---
* 500 uA for fast acquisition from cold start
.param Icp = 500e-6
.param Icp_mismatch = 0.02

* --- VCO ---
* Kvco = 50 MHz/V -- realistic for LC-VCO with switched-cap coarse tuning
* The coarse bank provides ~400 MHz range in 8 bands (~50 MHz/band)
* Fine varactor provides 50 MHz/V continuous tuning within each band
.param Kvco = 50e6

* --- Loop Filter (3rd-order passive) ---
* Designed for ~80 kHz loop bandwidth with 50 MHz/V Kvco
* Large C3 (200p) provides strong filtering at the 10 MHz reference
* frequency, reducing ctrl voltage ripple and improving stability.
*
* Zero frequency: fz = 1/(2*pi*R1*C1) = 79.6 kHz
* Third pole: fp3 = 1/(2*pi*R1*C3) = 398 kHz (well below fref=10MHz)
.param R1 = 2k
.param C1 = 1n
.param C2 = 100p
.param C3 = 200p
*==== END SECTION: PARAMS ====

*==== BEGIN SECTION: PFD ====
* ===========================================================================
* PHASE-FREQUENCY DETECTOR (PFD)
* ===========================================================================
* Standard tri-state PFD using two D flip-flops and an AND reset gate.
* When ref leads div_out: UP pulse is asserted.
* When div_out leads ref: DN pulse is asserted.
* Both asserted simultaneously triggers reset via AND gate.
*
* IMPORTANT: ngspice-45 d_dff pin order is:
*   a_name data clk SET RESET Q Qbar model
* Pin 3 = SET (active HIGH, forces Q HIGH)
* Pin 4 = RESET/CLEAR (active HIGH, forces Q LOW)
*
* We connect:
*   - Pin 3 (SET) = d_zero (always LOW, inactive)
*   - Pin 4 (RESET) = d_reset (AND gate output, clears on both UP+DN)
* ===========================================================================

* --- Reference clock source ---
Vref ref 0 dc 0 pulse(0 {vdd} 10n 1n 1n {1/fref/2} {1/fref})

* --- AND reset gate (detects both UP and DN high) ---
aand1 [d_up d_dn] d_reset and1
.model and1 d_and(rise_delay=0.1n fall_delay=0.5n input_load=0.5e-12)

* --- D flip-flop for UP path (clocked by ref) ---
* Pin order: data clk SET RESET Q Qbar
aff1 d_one ref_d d_zero d_reset d_up d_up_n flop1
.model flop1 d_dff(clk_delay=0.1n set_delay=0.1n reset_delay=0.1n
+ ic=0 rise_delay=0.1n fall_delay=0.1n)

* --- D flip-flop for DN path (clocked by div_out) ---
aff2 d_one div_out_d d_zero d_reset d_dn d_dn_n flop1

* --- DC constant sources ---
Vone one_a 0 dc {vdd}
Vzero zero_a 0 dc 0

* --- ADC bridges: analog to digital domain ---
abridge_const [one_a zero_a] [d_one d_zero] adc1
abridge_ref [ref] [ref_d] adc1
abridge_div [div_out] [div_out_d] adc1
.model adc1 adc_bridge(in_low=0.5 in_high=2.5 rise_delay=0.1n fall_delay=0.1n)

* --- DAC bridges: digital to analog ---
abridge_updn [d_up d_dn] [up_a dn_a] dac1
.model dac1 dac_bridge(out_low=0 out_high={vdd} out_undef={vdd/2}
+ input_load=5e-12 t_rise=0.1n t_fall=0.1n)
*==== END SECTION: PFD ====

*==== BEGIN SECTION: CHARGE_PUMP ====
* ===========================================================================
* CHARGE PUMP
* ===========================================================================
* Current-steering charge pump with configurable mismatch.
* UP current sources charge (increase Vctrl), DN current sinks discharge.
* Mismatch between UP and DN currents is modeled as a percentage offset
* (Icp_mismatch = 0.02 means 2% total mismatch).
*
* In silicon, mismatch arises from:
*   - PMOS vs NMOS current mirror offset
*   - Channel length modulation differences
*   - Threshold voltage mismatch
*
* SPICE convention: for B-source connected ctrl -> 0, positive I flows
* from ctrl to ground (discharging). Negative I flows from ground to ctrl
* (charging). So:
*   - UP asserted: negative I charges ctrl (increases voltage)
*   - DN asserted: positive I discharges ctrl (decreases voltage)
* ===========================================================================

* --- UP current source (charges ctrl node -- current flows into ctrl) ---
Bcp_up ctrl 0 I = -{Icp*(1+Icp_mismatch/2)} * max(0, (v(up_a)-{vdd/2})/{vdd/2})

* --- DN current source (discharges ctrl node -- current flows out of ctrl) ---
Bcp_dn ctrl 0 I = {Icp*(1-Icp_mismatch/2)} * max(0, (v(dn_a)-{vdd/2})/{vdd/2})
*==== END SECTION: CHARGE_PUMP ====

*==== BEGIN SECTION: LOOP_FILTER ====
* ===========================================================================
* LOOP FILTER (3rd-order passive)
* ===========================================================================
* Topology: Standard CP-PLL passive loop filter
*
*   ctrl ----+----[R1]----+---- lf_zero
*            |            |
*           [C2]         [C1]
*            |            |
*           GND          GND
*            |
*           [C3]
*            |
*           GND
*
* Transfer function provides:
*   - One zero at omega_z = 1/(R1*C1) for phase margin
*   - Two poles for noise filtering:
*       omega_p1 = (C1+C2)/(R1*C1*C2)
*       omega_p2 from C3
*
* Design targets (with Icp=200uA, Kvco=150MHz/V, N=240):
*   - Loop bandwidth: ~50 kHz
*   - Phase margin: ~60 degrees
*   - Zero frequency: 1/(2*pi*R1*C1) = 1/(2*pi*4.35k*470p) = 77.9 kHz
*   - First pole: (C1+C2)/(2*pi*R1*C1*C2) = 538p/(2*pi*4.35k*470p*68p)
*
* Additional elements:
*   - Rleak: prevents ctrl from floating if CP is off (1 GOhm)
*   - Clamp diodes: keep ctrl within VCO supply range
* ===========================================================================

* --- R1 + C1 series path (provides stabilizing zero) ---
R_lf1 ctrl lf_zero {R1}
C_lf1 lf_zero 0 {C1}

* --- C2 shunt from ctrl to ground (main integration) ---
C_lf2 ctrl 0 {C2}

* --- C3 for additional high-frequency pole ---
C_lf3 ctrl 0 {C3}

* --- Leakage resistor to prevent floating node ---
Rleak ctrl 0 1G

* --- Voltage clamps to keep ctrl within VCO input range ---
Dclamp_hi ctrl vdd_node dmod
Dclamp_lo gnd_node ctrl dmod
Vvdd_clamp vdd_node 0 dc {vdd}
Vgnd_clamp gnd_node 0 dc 0
.model dmod d(is=1e-14 n=1)
*==== END SECTION: LOOP_FILTER ====

*==== BEGIN SECTION: VCO ====
* ===========================================================================
* VOLTAGE-CONTROLLED OSCILLATOR (VCO)
* ===========================================================================
* LC-VCO modeled with XSPICE d_osc element.
* Piecewise-linear voltage-to-frequency characteristic.
*
* Kvco = 50 MHz/V (realistic for LC-VCO with switched-capacitor bank)
* In a real design:
*   - 3-bit capacitor bank provides ~400 MHz coarse tuning range
*   - Each band covers ~50 MHz
*   - MOS varactor provides fine tuning within each band (Kvco = 50 MHz/V)
*   - Digital calibration selects the correct coarse band at startup
*
* Center frequency: 2.4 GHz at Vctrl = Vco_center = 1.65V
*
* Frequency mapping:
*   f_out = 2.4 GHz + Kvco * (Vctrl - Vco_center)
*   V=0.0V  -> 2.4G + 50M*(0.0-1.65)  = 2.3175 GHz
*   V=0.5V  -> 2.4G + 50M*(0.5-1.65)  = 2.3425 GHz
*   V=1.0V  -> 2.4G + 50M*(1.0-1.65)  = 2.3675 GHz
*   V=1.65V -> 2.4G + 50M*(1.65-1.65) = 2.4000 GHz
*   V=2.0V  -> 2.4G + 50M*(2.0-1.65)  = 2.4175 GHz
*   V=2.5V  -> 2.4G + 50M*(2.5-1.65)  = 2.4425 GHz
*   V=3.0V  -> 2.4G + 50M*(3.0-1.65)  = 2.4675 GHz
*   V=3.3V  -> 2.4G + 50M*(3.3-1.65)  = 2.4825 GHz
* ===========================================================================

avco ctrl d_vco vco_model
.model vco_model d_osc(cntl_array=[0.0 0.5 1.0 1.65 2.0 2.5 3.0 3.3]
+ freq_array=[2.3175e9 2.3425e9 2.3675e9 2.4e9 2.4175e9 2.4425e9 2.4675e9 2.4825e9]
+ duty_cycle=0.5 init_phase=0
+ rise_delay=0.05n fall_delay=0.05n)
*==== END SECTION: VCO ====

*==== BEGIN SECTION: DIVIDER ====
* ===========================================================================
* FREQUENCY DIVIDER
* ===========================================================================
* Integer-N frequency divider using XSPICE d_fdiv element.
* Divides VCO output by Ndiv=240 to produce the feedback signal.
*
* f_div = f_vco / Ndiv = 2.4 GHz / 240 = 10 MHz (matches fref)
*
* In a real design, this would be implemented as:
*   - Prescaler (divide by 2/3, current-mode logic for speed)
*   - Programmable counter (CMOS logic)
*   - Swallow counter for fractional-N operation
*
* The divider output is converted back to analog domain via a DAC bridge
* so it can drive the PFD's analog-side D flip-flop clock input.
* ===========================================================================

* --- Frequency divider (VCO digital output -> divided digital output) ---
adiv1 d_vco d_divided fdiv1
.model fdiv1 d_fdiv(div_factor={Ndiv} i_count=0
+ rise_delay=0.1n fall_delay=0.1n)

* --- DAC bridge: divider digital output -> analog for PFD feedback ---
abridge_divout [d_divided] [div_out] dac_div
.model dac_div dac_bridge(out_low=0 out_high={vdd} out_undef={vdd/2}
+ input_load=5e-12 t_rise=0.1n t_fall=0.1n)
*==== END SECTION: DIVIDER ====

*==== BEGIN SECTION: SIGMA_DELTA ====
* ===========================================================================
* SIGMA-DELTA MODULATOR (placeholder)
* ===========================================================================
* For fractional-N operation, a sigma-delta modulator dynamically
* varies the divider ratio between N and N+1 such that the average
* division ratio equals the desired fractional value.
*
* Benefits:
*   - Pushes quantization noise to high frequencies (noise shaping)
*   - Enables fine frequency resolution without fractional spurs
*   - Combined with the loop filter, quantization noise is suppressed
*
* Implementation would require:
*   - MASH 1-1-1 (3rd order) sigma-delta modulator
*   - Digital accumulator chain
*   - Modulus control of the prescaler
*
* Currently operating as integer-N (Ndiv=240 fixed).
* To enable fractional-N, the d_fdiv div_factor would need to be
* dynamically modulated, which requires behavioral Verilog-A or
* a more complex XSPICE implementation.
* ===========================================================================
* (No active circuit elements -- integer-N mode)
*==== END SECTION: SIGMA_DELTA ====

*==== BEGIN SECTION: SIM_CONTROL ====
* ===========================================================================
* INITIAL CONDITIONS AND SIMULATION CONTROL
* ===========================================================================
* Starting from V(ctrl)=0V to demonstrate genuine locking behavior.
* With Kvco=150MHz/V and Icp=500uA, the PLL must slew ctrl from
* 0V to ~1.65V and then settle. This requires several hundred
* microseconds of simulation.
*
* Using 500 us simulation to capture full lock and steady-state.
* Timestep increased to 1ns to keep memory and runtime manageable.
* ===========================================================================

* --- Initial conditions: start from 0V (realistic cold start) ---
.ic v(ctrl)=0 v(lf_zero)=0

.control
set filetype=ascii

* Save only needed signals to keep memory manageable
save ref div_out ctrl up_a dn_a

* Transient simulation: 500 us total, 1 ns timestep
tran 1n 500u uic

* === MEASUREMENTS ===
* Final control voltage (should settle near Vco_center for 2.4 GHz)
meas tran ctrl_final find v(ctrl) at=500u

* Ripple in steady state (last 20% of simulation)
meas tran ctrl_max max v(ctrl) from=400u to=500u
meas tran ctrl_min min v(ctrl) from=400u to=500u
meas tran ctrl_avg avg v(ctrl) from=400u to=500u

* Lock time measurement: when ctrl first reaches 95% of final value
let lock_target = ctrl_final * 0.95
meas tran lock_time trig at=0 targ v(ctrl) val=$&lock_target rise=1

* Compute ripple
let ctrl_ripple = ctrl_max - ctrl_min

* === WRITE METRICS FILE ===
echo "=== PLL METRICS ===" > metrics.txt
echo "lock_time: $&lock_time" >> metrics.txt
echo "ctrl_final: $&ctrl_final" >> metrics.txt
echo "ctrl_max: $&ctrl_max" >> metrics.txt
echo "ctrl_min: $&ctrl_min" >> metrics.txt
echo "ctrl_avg: $&ctrl_avg" >> metrics.txt
echo "ctrl_ripple: $&ctrl_ripple" >> metrics.txt
echo "icp: 500e-6" >> metrics.txt
echo "kvco: 50e6" >> metrics.txt
echo "vdd: 3.3" >> metrics.txt
echo "=== END METRICS ===" >> metrics.txt

* === EXPORT WAVEFORMS ===
wrdata ctrl_waveform.txt v(ctrl)
wrdata ref_waveform.txt v(ref)
wrdata divout_waveform.txt v(div_out)
wrdata up_waveform.txt v(up_a)
wrdata dn_waveform.txt v(dn_a)

echo "Simulation complete."
quit
.endc

.end
*==== END SECTION: SIM_CONTROL ====
